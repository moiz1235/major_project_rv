ADE simulation setup
Run mode: Monte Carlo Sampling
Tests:
  ALU:inv_test:1: ALU/inv_test/schematic, simulator spectre
Monte Carlo Sampling options: mcmethod=all, mcnumpoints=100

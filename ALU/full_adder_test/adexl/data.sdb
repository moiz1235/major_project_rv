ADE simulation setup
Run mode: Monte Carlo Sampling
Tests:
  ALU:full_adder_test:1: ALU/full_adder_test/schematic, simulator spectre
Monte Carlo Sampling options: mcmethod=all, mcnumpoints=100
